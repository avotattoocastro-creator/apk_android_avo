* AVO GIRTH REV B · mc_ventana_036
.include /home/runner/work/apk_android_avo/apk_android_avo/hardware/girth/PCB/AUDITORIA_REV_B/spice/modelos.lib
.func sw(x) {0.5*(1+tanh(x/0.005))}
XQ10 VBAT PWR_PG BAT_RAW PMOS_LVL1 PARAMS: VTO=-0.820076 KP=7.00312
XQ11 PWR_PG PWR_G 0 NMOS_LVL1 PARAMS: VTO=1.2264 KP=16.3579
XD10a VIN5 PWR_G BAV70
XD10b PWR_HOLD PWR_G BAV70
XD11a REED_PULSE PWR_G BAV70
XD11b REED_PULSE PWR_G BAV70
XD12a REED_HI REED_C BAV70
XD12b REED_HI REED_C BAV70
XD13a 0 REED_PULSE BAV70
XD13b 0 REED_PULSE BAV70
RR40 BAT_RAW PWR_PG 100847
RR41 REED_PULSE 0 1.00661e+07
RR42 PWR_G 0 9.97197e+06
RR43 PWR_HOLD 0 99229.5
RR44 REED_C REED_CR 220.986
RR45 REED_C 0 999032
CC40 REED_CR REED_PULSE 2.30778e-06
CC41 PWR_G 0 5.0958e-07
XQ16 REED REED_G 0 NMOS_LVL1 PARAMS: VTO=2.04565 KP=0.169242
RR49 REED_HI REED_G 100000
RR50 REED_G 0 1e+06
RR31 REED VDD3 100000
CC33 REED 0 1e-08
RR32 VBAT BAT_ADC 1e+06
RR33 BAT_ADC 0 1e+06
CC34 BAT_ADC 0 1e-07
CC20 VBAT 0 6e-06
CC19 VSYS 0 6e-06
CC21 VSYS 0 6e-06
CC22 VDD3 0 7e-06
CC23 VDD3 0 1.1e-05
CC24 VDD3 0 1e-07
VCELL CELL 0 DC 3.56144
RCELL CELL BAT_RAW 0.2
SREED BAT_RAW REED_HI REEDCTL 0 SWREED
.model SWREED SW(VT=0.5 VH=0.1 RON=0.1 ROFF=1e12)
VREED REEDCTL 0 DC 0 PWL(0 0 0.1 0 0.101 1)
VVIN VIN5S 0 DC 0 PWL(0 0)
RVIN VIN5S VIN5 0.5
CC18 VIN5 0 1u
RPATH VBAT VSYS 0.05
BCHG 0 VSYS I = sw(V(VIN5)-4.3) * 0.01*ln(1 + exp((4.4 - V(VSYS))/0.01)) / 0.1
XU3 VSYS VDD3 0 RT9080 PARAMS: RDO=0.516667 VREG=3.3
CTIM TIM 0 1u
RTIM TIM 0 1e9
BTIM 0 TIM I = sw(V(VDD3)-2.8)*(1-V(RST))*1e-6 - (sw(2.8-V(VDD3)) + V(RST))*1e-3*V(TIM)
VRST RST 0 DC 0 PWL(0 0)
VHCMD HCMD 0 DC 0 PWL(0 0)
BHOLD 0 PWR_HOLD I = sw(V(VDD3)-2.0) * (1-V(RST)) * sw(V(TIM)-99) * ( V(HCMD)*(V(VDD3)-V(PWR_HOLD)) + (1-V(HCMD))*(0-V(PWR_HOLD)) ) / 40
VTX TXG 0 PULSE(0 1 0 10u 10u 0.002 0.01)
BLOAD VDD3 0 I = sw(V(VDD3)-2.51) * (1-V(RST)*0.7) * ( sw(99-V(TIM))*0.060 + sw(V(TIM)-99)*(V(SLP)*20e-6 + (1-V(SLP))*(0.082 + sw(V(TIM)-99-0.2)*V(TXG)*0.268)) )
VSLP SLP 0 DC 0 PWL(0 0)
.options method=gear reltol=1e-4 abstol=1e-12
.control
set wr_singlescale
set wr_vecnames
tran 0.002 6 0 0.002
wrdata hardware/girth/PCB/AUDITORIA_REV_B/resultados_ci/spice_rev_b1/mc_ventana_036.dat V(VDD3)
quit
.endc
.end
